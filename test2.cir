* ===================================================
* Описание модели диода (например, популярный 1N4148)
* ===================================================
* D — тип модели (диод). IS — ток насыщения, RS — сопротивление, BV — пробой
.model MyDiode D(IS=4.35e-9 RS=0.64 BV=110)

* ===================================================
* Главная схема
* ===================================================
* Источник синусоидального сигнала: смещение=0, амплитуда=5V, частота=1kHz
Vsin v_in 0 sine(0 5 1k)

* Диод подключен анодом к v_in, катодом к v_out
D1 v_in v_out MyDiode

* Нагрузочный резистор
Rload v_out 0 1k

* ===================================================
* Анализ (Переходный процесс во времени)
* ===================================================
.control
    * tran: шаг=10мкс, конечное время=3мс (увидим 3 полных периода)
    tran 10u 3m

    * Строим график: входной сигнал и выпрямленный выходной
    plot v(v_in) v(v_out)

    gview
.endc

.end
