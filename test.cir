Main Simulation File with External Library
* Подключаем внешний файл с субсхемами
.INCLUDE my_library.sub

* Главная схема
v1 v_in 0 dc 10
x1 v_in v_out 0 test_div r1=3k r2=1k

* Блок управления
.control
    op
    print v(v_in) v(v_out)
    quit
.endc

.end
