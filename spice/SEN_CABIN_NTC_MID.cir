* Ngspice тест: SEN_CABIN / SEN_CABIN_NTC_MID
* Термистор RT1 при комнатной температуре 25°C.
* R_NTC = 10 кОм.
* NTC_CABIN = 3.3 · 10/(10 + 10) = 1.65В.
.INCLUDE spice/SEN_CABIN.sub

* Порты: GND M_FAN_CTL NTC_CABIN

* V1: Опорное питание АЦП
V1 VCC_3V3_EXT 0 DC 3.3

* R_PU: R24 (10к) — верхнее плечо делителя
R_PU VCC_3V3_EXT NTC_CABIN 10k
XSEN_CABIN 0 M_FAN_CTL NTC_CABIN SEN_CABIN RT1_T=25

.op
.control
run
print v(ntc_cabin)
.endc
.end
