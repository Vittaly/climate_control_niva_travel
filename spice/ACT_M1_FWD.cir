* Ngspice тест: ACT (порт-интерфейс из KiCad)
.INCLUDE drv8871_ngspice.lib

.INCLUDE spice/ACT.sub
.model MyD D(IS=4.35e-9 RS=0.64 BV=110)
.model TVS24 D(IS=4.35e-9 RS=0.64 BV=8)
.model TVS5 D(IS=4.35e-9 RS=0.64 BV=5.6)
.model SW_GP SW(Ron=0.1 Roff=1Meg Vt=1.5 Vh=0.5)

* Порты: FB_M1 FB_M1_RAW FB_M2 FB_M2_RAW FB_M3 FB_M3_RAW FB_M4 FB_M4_RAW GND ILIM_1 ILIM_2 ILIM_3 ILIM_4 M1_IN1 M1_IN2 M2_IN1 M2_IN2 M3_IN1 M3_IN2 M4_IN1 M4_IN2 MOTOR_1_A MOTOR_1_B MOTOR_2_A MOTOR_2_B MOTOR_3_A MOTOR_3_B MOTOR_4_A MOTOR_4_B VCC_12V
XACT FB_M1 FB_M1_RAW FB_M2 FB_M2_RAW FB_M3 FB_M3_RAW FB_M4 FB_M4_RAW 0 ILIM_1 ILIM_2 ILIM_3 ILIM_4 M1_IN1 M1_IN2 M2_IN1 M2_IN2 M3_IN1 M3_IN2 M4_IN1 M4_IN2 MOTOR_1_A MOTOR_1_B MOTOR_2_A MOTOR_2_B MOTOR_3_A MOTOR_3_B MOTOR_4_A MOTOR_4_B VCC_12V ACT

VS VCC_12V 0 DC 14.4
V1 M1_IN1 0 DC 3.3
V2 M1_IN2 0 DC 0
.op
* PASS: MOTOR_1_A ~12В (H-мост, прямое вращение)
.control
op
print V(MOTOR_1_A)
run
.endc
.end
