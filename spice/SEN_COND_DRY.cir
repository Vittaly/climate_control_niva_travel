* Ngspice тест: condensate_sensor / SEN_COND_DRY
* Сухое стекло, датчик выдаёт 0В.
* COND_ADC = 0В.
.model D_ZENER_3V6 D(IS=1e-14 RS=100 N=1.05 BV=3.6 IBV=1m CJO=50p)
.INCLUDE spice/condensate_sensor.sub

* Порты: COND_ADC COND_IN_RAW GND

* V1: Датчик конденсата: сухо (0В)
V1 COND_IN_RAW 0 DC 0.0
Xcondensate_sensor COND_ADC COND_IN_RAW 0 condensate_sensor

.op
.control
run
print v(cond_adc)
.endc
.end
