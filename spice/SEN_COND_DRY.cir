* Ngspice тест: SEN_COND / SEN_COND_DRY
* Сухое стекло, датчик выдаёт 0В.
* COND_ADC = 0В.
.INCLUDE spice/SEN_COND.sub

* Порты: COND_ADC COND_RAW GND

* V1: Датчик конденсата: сухо (0В)
V1 COND_RAW 0 DC 0.0
XSEN_COND COND_ADC COND_RAW 0 SEN_COND

.op
.control
run
print v(cond_adc)
.endc
.end
