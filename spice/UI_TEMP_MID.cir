* Ngspice тест: UI / UI_TEMP_MID
* Потенциометр в середине (10к) → 1,65В
LED_GREEN D(IS=1e-20 N=1.8 RS=8 BV=5 CJO=10p)
LED_AMBER D(IS=1e-20 N=1.8 RS=8 BV=5 CJO=10p)
SW_GP    SW(Ron=0.1 Roff=1Meg Vt=1.5 Vh=0.5)
.INCLUDE spice/UI.sub

* Порты: BTN_DRY_GLASS BTN_FACE BTN_FEET FAN_SEL_ADC GND LED_AC_DRV LED_DEFROST_GLASS_DRV LED_DRY_GLASS_DRV LED_FACE_DRV LED_FEET_DRV LED_RECIRC_DRV

V1 VCC_3V3 0 DC 3.3

R_POT TEMP_SET_ADC 0 10k
XUI BTN_DRY_GLASS BTN_FACE BTN_FEET FAN_SEL_ADC 0 LED_AC_DRV LED_DEFROST_GLASS_DRV LED_DRY_GLASS_DRV LED_FACE_DRV LED_FEET_DRV LED_RECIRC_DRV UI

.op
.control
run
print v(temp_set_adc)
.endc
.end
