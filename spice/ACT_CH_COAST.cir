* Ngspice тест: actuator_channel / ACT_CH_COAST
* Выбег. IN1 = L, IN2 = L — оба плеча Hi-Z, на моторедуктор
* питание не подаётся. Выходы висят на средней точке VM/2,
* определяемой body-диодами драйвера и обмоткой мотора.
* Ток через мотор = 0, скорость не нарастает.
.INCLUDE /home/vitaly-pc/kicad/climate_control_niva_travel/spice/lib/motor_model.lib
.INCLUDE /home/vitaly-pc/kicad/climate_control_niva_travel/spice/lib/drv8871_ngspice.lib
.INCLUDE spice/actuator_channel.sub

* Порты: FB FB_RAW GND ILIM IN1 IN2 MOTOR_A MOTOR_B VCC_12V

* V1: Питание H-моста
V1 VCC_12V 0 DC 14.4

* V2: IN1 = лог. 0
V2 IN1 0 DC 0.0

* V3: IN2 = лог. 0
V3 IN2 0 DC 0.0

* XM: Тот же моторедуктор, без питания
XM MOTOR_A MOTOR_B SPEED DC_MOTOR R_arm=30 L_arm=50m Ke=40 Kt=0.05 C_inertia=1e-4 R_friction=30
Xactuator_channel FB FB_RAW 0 ILIM IN1 IN2 MOTOR_A MOTOR_B VCC_12V actuator_channel

.op
.control
run
let vsw = v(MOTOR_A) - v(MOTOR_B)
let vspeed = v(SPEED)
print v(motor_a) v(motor_b) vsw vspeed
.endc
.end
