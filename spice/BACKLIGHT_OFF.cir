* Ngspice тест: BACKLIGHT / BACKLIGHT_OFF
* Габариты выключены, ILLUM_IN_RAW = 0.
* LED не светятся, ток через каналы ≈ 0.
.INCLUDE spice/BACKLIGHT.sub

* Порты: GND ILLUM_IN_RAW NET_BTN_CH1_A NET_BTN_CH1_B NET_BTN_CH1_C NET_BTN_CH2_A NET_BTN_CH2_B NET_BTN_CH2_C NET_PTR_CH1_A NET_PTR_CH1_B NET_PTR_CH1_C NET_PTR_CH2_A NET_PTR_CH2_B NET_PTR_CH2_C NET_PTR_CH3_A NET_PTR_CH3_B NET_PTR_CH3_C NET_PTR_CH4_A NET_PTR_CH4_B NET_PTR_CH4_C NET_SCALE_CH1_A NET_SCALE_CH1_B NET_SCALE_CH1_C NET_SCALE_CH2_A NET_SCALE_CH2_B NET_SCALE_CH2_C NET_SCALE_CH3_A NET_SCALE_CH3_B NET_SCALE_CH3_C NET_SCALE_CH4_A NET_SCALE_CH4_B NET_SCALE_CH4_C NET_SCALE_CH5_A NET_SCALE_CH5_B NET_SCALE_CH5_C NET_SCALE_CH6_A NET_SCALE_CH6_B NET_SCALE_CH6_C NET_SCALE_CH7_A NET_SCALE_CH7_B NET_SCALE_CH7_C NET_SCALE_CH8_A NET_SCALE_CH8_B NET_SCALE_CH8_C

* V1: Габариты выключены
V1 ILLUM_IN_RAW 0 DC 0.0
XBACKLIGHT 0 ILLUM_IN_RAW NET_BTN_CH1_A NET_BTN_CH1_B NET_BTN_CH1_C NET_BTN_CH2_A NET_BTN_CH2_B NET_BTN_CH2_C NET_PTR_CH1_A NET_PTR_CH1_B NET_PTR_CH1_C NET_PTR_CH2_A NET_PTR_CH2_B NET_PTR_CH2_C NET_PTR_CH3_A NET_PTR_CH3_B NET_PTR_CH3_C NET_PTR_CH4_A NET_PTR_CH4_B NET_PTR_CH4_C NET_SCALE_CH1_A NET_SCALE_CH1_B NET_SCALE_CH1_C NET_SCALE_CH2_A NET_SCALE_CH2_B NET_SCALE_CH2_C NET_SCALE_CH3_A NET_SCALE_CH3_B NET_SCALE_CH3_C NET_SCALE_CH4_A NET_SCALE_CH4_B NET_SCALE_CH4_C NET_SCALE_CH5_A NET_SCALE_CH5_B NET_SCALE_CH5_C NET_SCALE_CH6_A NET_SCALE_CH6_B NET_SCALE_CH6_C NET_SCALE_CH7_A NET_SCALE_CH7_B NET_SCALE_CH7_C NET_SCALE_CH8_A NET_SCALE_CH8_B NET_SCALE_CH8_C BACKLIGHT

.op
.control
run
let itot = -i(V1)
print itot
.endc
.end
