* Ngspice тест: UI (порт-интерфейс из KiCad)

.INCLUDE spice/UI.sub
.model MyD D(IS=4.35e-9 RS=0.64 BV=110)
.model TVS24 D(IS=4.35e-9 RS=0.64 BV=8)
.model TVS5 D(IS=4.35e-9 RS=0.64 BV=5.6)
.model SW_GP SW(Ron=0.1 Roff=1Meg Vt=1.5 Vh=0.5)

* Порты: BTN_AC BTN_DEFROST_GLASS BTN_DRY_GLASS BTN_FACE BTN_FEET BTN_RECIRC FAN_SEL_ADC GND ILLUM_IN_RAW ILLUM_SENSE LED_AC_A LED_AC_DRV LED_DEFROST_GLASS_A LED_DEFROST_GLASS_DRV LED_DRY_GLASS_A LED_DRY_GLASS_DRV LED_FACE_A LED_FACE_DRV LED_FEET_A LED_FEET_DRV LED_RECIRC_A LED_RECIRC_DRV NTC_CABIN TEMP_SET_ADC VCC_3V3
XUI BTN_AC BTN_DEFROST_GLASS BTN_DRY_GLASS BTN_FACE BTN_FEET BTN_RECIRC FAN_SEL_ADC 0 ILLUM_IN_RAW ILLUM_SENSE LED_AC_A LED_AC_DRV LED_DEFROST_GLASS_A LED_DEFROST_GLASS_DRV LED_DRY_GLASS_A LED_DRY_GLASS_DRV LED_FACE_A LED_FACE_DRV LED_FEET_A LED_FEET_DRV LED_RECIRC_A LED_RECIRC_DRV NTC_CABIN TEMP_SET_ADC VCC_3V3 UI

VS VCC_3V3 0 DC 3.3
.op
* PASS: FAN_SEL_ADC в рабочем окне (AUTO)
.control
op
print V(FAN_SEL_ADC)
run
.endc
.end
