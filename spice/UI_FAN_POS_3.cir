* Ngspice тест: user_interface / UI_FAN_POS_3
* Галлетник в позиции 3. R27 (4,7к) → 1,05В.
.model LED_GREEN D(IS=1e-20 N=1.8 RS=8 BV=5 CJO=10p)
.model LED_AMBER D(IS=1e-20 N=1.8 RS=8 BV=5 CJO=10p)
.INCLUDE spice/user_interface.sub

* Порты: BTN_AC BTN_DEFROST_GLASS BTN_DRY_GLASS BTN_FACE BTN_FEET BTN_RECIRC FAN_SEL_ADC GALLET_POS_1 GALLET_POS_2 GALLET_POS_3 GALLET_POS_4 GND ILLUM_IN_RAW ILLUM_SENSE LED_AC_A LED_AC_DRV LED_DEFROST_GLASS_A LED_DEFROST_GLASS_DRV LED_DRY_GLASS_A LED_DRY_GLASS_DRV LED_FACE_A LED_FACE_DRV LED_FEET_A LED_FEET_DRV LED_RECIRC_A LED_RECIRC_DRV NTC_CABIN TEMP_SET_ADC VCC_3V3

V1 VCC_3V3 0 DC 3.3

* V_G3: Галлетник в позиции 3: замкнут POS_3
V_G3 GALLET_POS_3 0 DC 0.0
Xuser_interface BTN_AC BTN_DEFROST_GLASS BTN_DRY_GLASS BTN_FACE BTN_FEET BTN_RECIRC FAN_SEL_ADC GALLET_POS_1 GALLET_POS_2 GALLET_POS_3 GALLET_POS_4 0 ILLUM_IN_RAW ILLUM_SENSE LED_AC_A LED_AC_DRV LED_DEFROST_GLASS_A LED_DEFROST_GLASS_DRV LED_DRY_GLASS_A LED_DRY_GLASS_DRV LED_FACE_A LED_FACE_DRV LED_FEET_A LED_FEET_DRV LED_RECIRC_A LED_RECIRC_DRV NTC_CABIN TEMP_SET_ADC VCC_3V3 user_interface

.op
.control
run
print v(fan_sel_adc)
.endc
.end
