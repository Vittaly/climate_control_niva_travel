* Ngspice тест: solar_sensor / SEN_SOLAR_DARK
* Датчик в темноте, на выходе 0В.
* SOLAR_ADC = 0В.
.model D_ZENER_3V6 D(IS=1e-14 RS=100 N=1.05 BV=3.6 IBV=1m CJO=50p)
.INCLUDE spice/solar_sensor.sub

* Порты: GND SOLAR_ADC SOLAR_IN_RAW

* V1: Датчик солнечной радиации: темнота (0В)
V1 SOLAR_IN_RAW 0 DC 0.0
Xsolar_sensor 0 SOLAR_ADC SOLAR_IN_RAW solar_sensor

.op
.control
run
print v(solar_adc)
.endc
.end
