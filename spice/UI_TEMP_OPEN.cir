* Ngspice тест: UI / UI_TEMP_OPEN
* Потенциометр отключён, R22 подтягивает к 3,3В
LED_GREEN D(IS=1e-20 N=1.8 RS=8 BV=5 CJO=10p)
LED_AMBER D(IS=1e-20 N=1.8 RS=8 BV=5 CJO=10p)
SW_GP    SW(Ron=0.1 Roff=1Meg Vt=1.5 Vh=0.5)
.INCLUDE spice/UI.sub

* Порты: BTN_AC BTN_DEFROST_GLASS BTN_DRY_GLASS BTN_FACE BTN_FEET BTN_RECIRC FAN_SEL_ADC GALLET_POS_1 GALLET_POS_2 GALLET_POS_3 GALLET_POS_4 GND ILLUM_IN_RAW ILLUM_SENSE LED_AC_DRV LED_DEFROST_GLASS_DRV LED_DRY_GLASS_DRV LED_FACE_DRV LED_FEET_DRV LED_RECIRC_DRV NTC_CABIN TEMP_SET_ADC VCC_3V3

V1 VCC_3V3 0 DC 3.3
XUI BTN_AC BTN_DEFROST_GLASS BTN_DRY_GLASS BTN_FACE BTN_FEET BTN_RECIRC FAN_SEL_ADC GALLET_POS_1 GALLET_POS_2 GALLET_POS_3 GALLET_POS_4 0 ILLUM_IN_RAW ILLUM_SENSE LED_AC_DRV LED_DEFROST_GLASS_DRV LED_DRY_GLASS_DRV LED_FACE_DRV LED_FEET_DRV LED_RECIRC_DRV NTC_CABIN TEMP_SET_ADC VCC_3V3 UI

.op
.control
run
print v(temp_set_adc)
.endc
.end
