* Ngspice тест: OUT / OUT_FAN_ON
* FAN_PWM_CTL = 3,3В → Q1 открыт.
* FAN_PWM_NODE ≈ 0 через R14 + Rds_on, HEAT_FAN_PWM_CTL ≈ 0.
BSS138 NMOS(VTO=1.3 KP=0.5 LAMBDA=0.02)
MMBT3904 NPN(IS=1e-14 BF=200 VAF=100 IKF=0.3)
MMBT3906 PNP(IS=1e-14 BF=150 VAF=100 IKF=0.3)
.INCLUDE spice/OUT.sub

* Порты: AC_CTL AC_REQ_OUT FAN_PWM_CTL GND HEAT_FAN_PWM_CTL VCC_12V

* V1: Питание модуля +14,4В
V1 VCC_12V 0 DC 14.4

* V2: ШИМ-вход с МК = 3,3В (буфер открыт)
V2 FAN_PWM_CTL 0 DC 3.3
XOUT AC_CTL AC_REQ_OUT FAN_PWM_CTL 0 HEAT_FAN_PWM_CTL VCC_12V OUT

.op
.control
run
print v(heat_fan_pwm_ctl)
.endc
.end
