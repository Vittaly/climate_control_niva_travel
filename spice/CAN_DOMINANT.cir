* Ngspice тест: can_bus / CAN_DOMINANT
* Доминантное состояние шины (TXD = 0).
* Драйвер активен: CANH подтянут к 3,5В, CANL — к 1,5В.
* Vdiff ≈ 2,0В.
.INCLUDE /home/vitaly-pc/kicad/climate_control_niva_travel/spice/lib/mcp2562_ngspice.lib
.INCLUDE spice/can_bus.sub

* Порты: CANH CANL CAN_RX CAN_TX GND VCC_5V

* V1: Питание трансивера +5В
V1 VCC_5V 0 DC 5.0

* V2: TXD = 0 (доминант, драйвер активен)
V2 CAN_TX 0 DC 0.0

* R_TERM: Эквивалент двух терминаторов 120 Ом на концах шины
R_TERM CANH CANL 60
Xcan_bus CANH CANL CAN_RX CAN_TX 0 VCC_5V can_bus

.op
.control
run
let vh    = v(CANH)
let vl    = v(CANL)
let vdiff = v(CANH) - v(CANL)
print vh vl vdiff
.endc
.end
