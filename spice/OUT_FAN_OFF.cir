* Ngspice тест: OUT / OUT_FAN_OFF
* FAN_PWM_CTL = 0 → Q1 закрыт.
* FAN_PWM_NODE подтянут к 12В через R14, HEAT_FAN_PWM_CTL = 12В.
BSS138 NMOS(VTO=1.3 KP=0.5 LAMBDA=0.02)
MMBT3904 NPN(IS=1e-14 BF=200 VAF=100 IKF=0.3)
MMBT3906 PNP(IS=1e-14 BF=150 VAF=100 IKF=0.3)
.INCLUDE spice/OUT.sub

* Порты: AC_CTL AC_REQ_OUT GND

* V1: Питание модуля +14,4В
V1 VCC_12V 0 DC 14.4

* V2: ШИМ-вход с МК = 0 (буфер закрыт)
V2 FAN_PWM_CTL 0 DC 0.0
XOUT AC_CTL AC_REQ_OUT 0 OUT

.op
.control
run
print v(heat_fan_pwm_ctl)
.endc
.end
