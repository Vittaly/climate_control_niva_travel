* Ngspice тест: cabin_sensor / SEN_CABIN_FAN_OFF
* Мини-вентилятор продувки выключен.
* M_FAN_CTL = 0В → Q2 закрыт. SENS_FAN_SW подтягивается
* к VCC_12V через обмотку вентилятора (R_FAN = 100 Ом),
* ток через вентилятор ≈ 0.
.INCLUDE /home/vitaly-pc/kicad/climate_control_niva_travel/spice/lib/ntc_models.lib
.model D_1N4148 D(IS=2.52e-9 N=1.752 RS=0.568 CJO=4p BV=100)
.model AO3400A NMOS(LEVEL=3 VTO=1.4 KP=20 RS=0.02 RD=0.02 LAMBDA=0.02)
.INCLUDE spice/cabin_sensor.sub

* Порты: GND M_FAN_CTL M_FAN_GATE NTC_CABIN SENS_FAN_SW VCC_12V

* V1: Бортовая сеть +14,4В
V1 VCC_12V 0 DC 14.4

* V2: Управление вентилятором: ВЫКЛ
V2 M_FAN_CTL 0 DC 0.0

* R_FAN: Эквивалент обмотки вентилятора
R_FAN VCC_12V SENS_FAN_SW 100
Xcabin_sensor 0 M_FAN_CTL M_FAN_GATE NTC_CABIN SENS_FAN_SW VCC_12V cabin_sensor RT1_T=25

.op
.control
run
let vsw  = v(SENS_FAN_SW)
let ifan = (v(VCC_12V) - v(SENS_FAN_SW)) / 100
print vsw ifan
.endc
.end
