* Ngspice тест: SEN_CABIN / SEN_CABIN_FAN_OFF
* Мини-вентилятор продувки выключен.
* M_FAN_CTL = 0В → Q2 закрыт. SENS_FAN_SW подтягивается
* к VCC_12V через обмотку вентилятора (R_FAN = 100 Ом),
* ток через вентилятор ≈ 0.
.INCLUDE spice/SEN_CABIN.sub

* Порты: GND M_FAN_CTL M_FAN_GATE NTC_CABIN VCC_12V

* V1: Бортовая сеть +14,4В
V1 VCC_12V 0 DC 14.4

* V2: Управление вентилятором: ВЫКЛ
V2 M_FAN_CTL 0 DC 0.0

* R_FAN: Эквивалент обмотки вентилятора
R_FAN VCC_12V SENS_FAN_SW 100
XSEN_CABIN 0 M_FAN_CTL M_FAN_GATE NTC_CABIN VCC_12V SEN_CABIN

.op
.control
run
let vsw  = v(SENS_FAN_SW)
let ifan = (v(VCC_12V) - v(SENS_FAN_SW)) / 100
print vsw ifan
.endc
.end
