* Ngspice тест: CAN (порт-интерфейс из KiCad)

.INCLUDE mcp2562_ngspice.lib

.INCLUDE spice/CAN.sub
.model MyD D(IS=4.35e-9 RS=0.64 BV=110)
.model TVS24 D(IS=4.35e-9 RS=0.64 BV=8)
.model TVS5 D(IS=4.35e-9 RS=0.64 BV=5.6)
.model SW_GP SW(Ron=0.1 Roff=1Meg Vt=1.5 Vh=0.5)

* Порты: CANH CANL CAN_RX CAN_TX GND VCC_5V
XCAN CANH CANL CAN_RX CAN_TX 0 VCC_5V CAN

VS VCC_5V 0 DC 5
V1 CAN_TX 0 DC 5
.op
* PASS: CANH ~2,5В (рецессивный уровень)
.control
op
print V(CANH)
run
.endc
.end
