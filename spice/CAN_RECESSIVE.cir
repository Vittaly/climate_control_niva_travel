* Ngspice тест: CAN / CAN_RECESSIVE
* Рецессивное состояние шины (TXD = 1).
* Драйвер выключен, выходы CANH/CANL подтянуты внутренними
* делителями к ~2,5В. Vdiff ≈ 0.
.INCLUDE spice/CAN.sub

* Порты: CANH CANL CAN_RX CAN_TX GND

* V1: Питание трансивера +5В
V1 VCC_5V 0 DC 5.0

* V2: TXD = 1 (рецессив, драйвер выключен)
V2 CAN_TX 0 DC 5.0
XCAN CANH CANL CAN_RX CAN_TX 0 CAN

.op
.control
run
let vh    = v(CANH)
let vl    = v(CANL)
let vdiff = v(CANH) - v(CANL)
print vh vl vdiff
.endc
.end
