* Ngspice тест: can_bus / CAN_RX_PATH
* Проверка приёмного тракта.
* Подаём на CANH/CANL внешнее дифференциальное напряжение
* (имитация чужого передатчика на шине), проверяем RXD.
* При Vdiff > порога приёмника RXD = 0.
.INCLUDE /home/vitaly-pc/kicad/climate_control_niva_travel/spice/lib/mcp2562_ngspice.lib
.INCLUDE spice/can_bus.sub

* Порты: CANH CANL CAN_RX CAN_TX GND VCC_5V

* V1: Питание трансивера +5В
V1 VCC_5V 0 DC 5.0

* V2: TXD = 1 (свой драйвер выключен, слушаем шину)
V2 CAN_TX 0 DC 5.0

* V3: Внешний передатчик: CANH = 3,5В
V3 CANH 0 DC 3.5

* V4: Внешний передатчик: CANL = 1,5В
V4 CANL 0 DC 1.5

* R_TERM: Эквивалент двух терминаторов 120 Ом на концах шины
R_TERM CANH CANL 60
Xcan_bus CANH CANL CAN_RX CAN_TX 0 VCC_5V can_bus

.op
.control
run
let vrxd = v(CAN_RX)
print vrxd
.endc
.end
