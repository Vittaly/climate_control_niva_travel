* Ngspice тест: ACTUATOR_CHANNEL / ACT_CH_FWD
* Канал в прямом направлении.
* IN1 = H (3.3В), IN2 = L (0В) → MOTOR_A ≈ VCC, MOTOR_B ≈ GND.
.INCLUDE /home/vitaly-pc/kicad/climate_control_niva_travel/spice/lib/motor_model.lib
.INCLUDE spice/ACTUATOR_CHANNEL.sub

* Порты: FB FB_RAW GND IN1 IN2 MOTOR_A MOTOR_B

* V1: Питание H-моста (бортовая сеть под нагрузкой)
V1 VCC_12V 0 DC 14.4

* V2: Логический вход IN1 = лог. 1
V2 IN1 0 DC 3.3

* V3: Логический вход IN2 = лог. 0
V3 IN2 0 DC 0.0

* XM: Моторедуктор заслонки, типовые параметры.
XM MOTOR_A MOTOR_B SPEED DC_MOTOR R_arm=30 L_arm=50m Ke=40 Kt=0.05 C_inertia=1e-4 R_friction=30
XACTUATOR_CHANNEL FB FB_RAW 0 IN1 IN2 MOTOR_A MOTOR_B ACTUATOR_CHANNEL

.op
.control
run
print v(motor_a) v(motor_b) v(speed)
.endc
.end
