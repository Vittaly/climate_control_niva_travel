* Ngspice тест: solar_sensor / SEN_SOLAR_OPEN
* Обрыв линии датчика (провод перебит, датчик отключён).
* Линия SOLAR_IN_RAW висит в воздухе, ток через делитель = 0,
* SOLAR_ADC подтягивается к GND через R28 = 20к.
.model D_ZENER_3V6 D(IS=1e-14 RS=100 N=1.05 BV=3.6 IBV=1m CJO=50p)
.INCLUDE spice/solar_sensor.sub

* Порты: GND SOLAR_ADC SOLAR_IN_RAW

Xsolar_sensor 0 SOLAR_ADC SOLAR_IN_RAW solar_sensor

.op
.control
run
print v(solar_adc)
.endc
.end
