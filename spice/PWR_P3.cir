* Ngspice тест: PWR / PWR_P3
* Номинальный режим питания +5В.
* VBAT_IN = 14,4В, U6 (MC78M05) выдаёт +5В.
* Нагрузка имитируется резистором 100 Ом на VCC_5V.
D_SS54 D(IS=4.35e-9 RS=0.05 BV=40)
D_SS14 D(IS=4.35e-9 RS=0.05 BV=40)
TVS24 D(IS=4.35e-9 RS=0.64 BV=24)
TVS5  D(IS=4.35e-9 RS=0.64 BV=5.6)
.INCLUDE spice/PWR.sub

* Порты: AC_REQ_OUT CANH CANL COND_RAW FB_M1_RAW FB_M2_RAW FB_M3_RAW FB_M4_RAW GND HEAT_FAN_PWM_CTL ILLUM_IN_RAW MOTOR_1_A MOTOR_1_B MOTOR_2_A MOTOR_2_B MOTOR_3_A MOTOR_3_B MOTOR_4_A MOTOR_4_B NTC_HEAT_W SOLAR_RAW VCC_3V3 VCC_5V

* V1: Номинальная бортсеть +14,4В
V1 VBAT_IN 0 DC 14.4

* R_L5V: Нагрузка на +5В ≈ 50 мА
R_L5V VCC_5V 0 100
XPWR AC_REQ_OUT CANH CANL COND_RAW FB_M1_RAW FB_M2_RAW FB_M3_RAW FB_M4_RAW 0 HEAT_FAN_PWM_CTL ILLUM_IN_RAW MOTOR_1_A MOTOR_1_B MOTOR_2_A MOTOR_2_B MOTOR_3_A MOTOR_3_B MOTOR_4_A MOTOR_4_B NTC_HEAT_W SOLAR_RAW VCC_3V3 VCC_5V PWR

.op
.control
run
print v(vcc_5v)
.endc
.end
