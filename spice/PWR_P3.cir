* Ngspice тест: PWR / PWR_P3
* Номинальный режим питания +5В.
* VBAT_IN = 14,4В, U6 (MC78M05) выдаёт +5В.
* Нагрузка имитируется резистором 100 Ом на VCC_5V.
D_SS54 D(IS=4.35e-9 RS=0.05 BV=40)
D_SS14 D(IS=4.35e-9 RS=0.05 BV=40)
TVS24 D(IS=4.35e-9 RS=0.64 BV=24)
TVS5  D(IS=4.35e-9 RS=0.64 BV=5.6)
.INCLUDE spice/PWR.sub

* Порты: GND V5_SENS VBAT_IN

* V1: Номинальная бортсеть +14,4В
V1 VBAT_IN 0 DC 14.4

* R_L5V: Нагрузка на +5В ≈ 50 мА
R_L5V VCC_5V 0 100
XPWR 0 V5_SENS VBAT_IN PWR

.op
.control
run
print v(vcc_5v)
.endc
.end
