* Ngspice тест: SEN_HEAT (порт-интерфейс из KiCad)

.INCLUDE spice/SEN_HEAT.sub
.model MyD D(IS=4.35e-9 RS=0.64 BV=110)
.model TVS24 D(IS=4.35e-9 RS=0.64 BV=8)
.model TVS5 D(IS=4.35e-9 RS=0.64 BV=5.6)
.model SW_GP SW(Ron=0.1 Roff=1Meg Vt=1.5 Vh=0.5)

* Порты: GND NTC_HEAT NTC_HEAT_W VCC_3V3
XSEN_HEAT 0 NTC_HEAT NTC_HEAT_W VCC_3V3 SEN_HEAT

VS VCC_3V3 0 DC 3.3
VN NTC_HEAT_W 0 DC 0.6
.op
* PASS: NTC_HEAT < 1.5В (труба горячая)
.control
op
print V(NTC_HEAT)
run
.endc
.end
