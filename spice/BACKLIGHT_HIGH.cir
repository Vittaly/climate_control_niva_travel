* Ngspice тест: backlight / BACKLIGHT_HIGH
* Повышенное питание 14,4В (бортовая сеть с генератором).
* Ток канала растёт, но остаётся в пределах нормы LED (не более 30 мА).
.model LED_WHITE D(IS=1e-22 N=2.5 RS=6 BV=5 CJO=10p)
.INCLUDE spice/backlight.sub

* Порты: GND ILLUM_IN_RAW NET_BTN_CH1_A NET_BTN_CH1_B NET_BTN_CH1_C NET_BTN_CH2_A NET_BTN_CH2_B NET_BTN_CH2_C NET_PTR_CH1_A NET_PTR_CH1_B NET_PTR_CH1_C NET_PTR_CH2_A NET_PTR_CH2_B NET_PTR_CH2_C NET_PTR_CH3_A NET_PTR_CH3_B NET_PTR_CH3_C NET_PTR_CH4_A NET_PTR_CH4_B NET_PTR_CH4_C NET_SCALE_CH1_A NET_SCALE_CH1_B NET_SCALE_CH1_C NET_SCALE_CH2_A NET_SCALE_CH2_B NET_SCALE_CH2_C NET_SCALE_CH3_A NET_SCALE_CH3_B NET_SCALE_CH3_C NET_SCALE_CH4_A NET_SCALE_CH4_B NET_SCALE_CH4_C NET_SCALE_CH5_A NET_SCALE_CH5_B NET_SCALE_CH5_C NET_SCALE_CH6_A NET_SCALE_CH6_B NET_SCALE_CH6_C NET_SCALE_CH7_A NET_SCALE_CH7_B NET_SCALE_CH7_C NET_SCALE_CH8_A NET_SCALE_CH8_B NET_SCALE_CH8_C

* V1: Напряжение генератора +14,4В
V1 ILLUM_IN_RAW 0 DC 14.4
Xbacklight 0 ILLUM_IN_RAW NET_BTN_CH1_A NET_BTN_CH1_B NET_BTN_CH1_C NET_BTN_CH2_A NET_BTN_CH2_B NET_BTN_CH2_C NET_PTR_CH1_A NET_PTR_CH1_B NET_PTR_CH1_C NET_PTR_CH2_A NET_PTR_CH2_B NET_PTR_CH2_C NET_PTR_CH3_A NET_PTR_CH3_B NET_PTR_CH3_C NET_PTR_CH4_A NET_PTR_CH4_B NET_PTR_CH4_C NET_SCALE_CH1_A NET_SCALE_CH1_B NET_SCALE_CH1_C NET_SCALE_CH2_A NET_SCALE_CH2_B NET_SCALE_CH2_C NET_SCALE_CH3_A NET_SCALE_CH3_B NET_SCALE_CH3_C NET_SCALE_CH4_A NET_SCALE_CH4_B NET_SCALE_CH4_C NET_SCALE_CH5_A NET_SCALE_CH5_B NET_SCALE_CH5_C NET_SCALE_CH6_A NET_SCALE_CH6_B NET_SCALE_CH6_C NET_SCALE_CH7_A NET_SCALE_CH7_B NET_SCALE_CH7_C NET_SCALE_CH8_A NET_SCALE_CH8_B NET_SCALE_CH8_C backlight

.op
.control
run
let ich = -i(V1) / 14
print ich
.endc
.end
