* Ngspice тест: condensate_sensor / SEN_COND_MID
* Датчик в среднем положении — начало конденсации.
* COND_IN_RAW = 2,5В → COND_ADC ≈ 1,67В (K = 2/3).
.model D_ZENER_3V6 D(IS=1e-14 RS=100 N=1.05 BV=3.6 IBV=1m CJO=50p)
.INCLUDE spice/condensate_sensor.sub

* Порты: COND_ADC COND_IN_RAW GND

* V1: Датчик конденсата: середина диапазона (2,5В)
V1 COND_IN_RAW 0 DC 2.5
Xcondensate_sensor COND_ADC COND_IN_RAW 0 condensate_sensor

.op
.control
run
print v(cond_adc)
.endc
.end
