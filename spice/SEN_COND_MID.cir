* Ngspice тест: SEN_COND / SEN_COND_MID
* Датчик в среднем положении — начало конденсации.
* COND_RAW = 2,5В → COND_ADC ≈ 1,67В (K = 2/3).
.INCLUDE spice/SEN_COND.sub

* Порты: COND_ADC COND_RAW GND

* V1: Датчик конденсата: середина диапазона (2,5В)
V1 COND_RAW 0 DC 2.5
XSEN_COND COND_ADC COND_RAW 0 SEN_COND

.op
.control
run
print v(cond_adc)
.endc
.end
