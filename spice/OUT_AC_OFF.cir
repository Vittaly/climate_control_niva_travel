* Ngspice тест: power_outputs / OUT_AC_OFF
* AC_CTL = 0 → Q3 закрыт → R20 подтягивает базу Q4 к 12В → Q4 заперт.
* AC_REQ_OUT = 0 (внешний вход ЭБУ притянут к GND через R_ECU).
.model BSS138 NMOS(VTO=1.3 KP=0.5 LAMBDA=0.02)
.model MMBT3904 NPN(IS=1e-14 BF=200 VAF=100 IKF=0.3)
.model MMBT3906 PNP(IS=1e-14 BF=150 VAF=100 IKF=0.3)
.INCLUDE spice/power_outputs.sub

* Порты: AC_BASE AC_CTL AC_PNP_BASE AC_REQ AC_REQ_OUT FAN_GATE FAN_PWM_CTL FAN_PWM_NODE GND HEAT_FAN_PWM_CTL VCC_12V

* V1: Питание модуля +14,4В
V1 VCC_12V 0 DC 14.4

* V2: Управление запросом кондиционера = 0
V2 AC_CTL 0 DC 0.0

* R_ECU: Внешний вход ЭБУ (10 кОм на GND)
R_ECU AC_REQ_OUT 0 10k
Xpower_outputs AC_BASE AC_CTL AC_PNP_BASE AC_REQ AC_REQ_OUT FAN_GATE FAN_PWM_CTL FAN_PWM_NODE 0 HEAT_FAN_PWM_CTL VCC_12V power_outputs

.op
.control
run
print v(ac_req_out)
.endc
.end
