* Ngspice тест: BACKLIGHT / BACKLIGHT_ON
* Номинальное питание 12В от габаритов.
* Все 14 каналов открыты, каждый проводит ≈ 18 мА.
.INCLUDE spice/BACKLIGHT.sub

* Порты: GND NET_SCALE_CH2_C NET_SCALE_CH3_C NET_SCALE_CH5_C NET_SCALE_CH6_C NET_SCALE_CH7_C NET_SCALE_CH8_A NET_SCALE_CH8_C

* V1: Напряжение габаритов +12В
V1 ILLUM_IN_RAW 0 DC 12.0
XBACKLIGHT 0 NET_SCALE_CH2_C NET_SCALE_CH3_C NET_SCALE_CH5_C NET_SCALE_CH6_C NET_SCALE_CH7_C NET_SCALE_CH8_A NET_SCALE_CH8_C BACKLIGHT

.op
.control
run
let ich  = -i(V1) / 14
let vled = v(ILLUM_IN_RAW) - v(NET_SCALE_CH1_A)
print ich vled
.endc
.end
