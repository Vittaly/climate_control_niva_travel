* Ngspice тест: SEN_SOLAR / SEN_SOLAR_MID
* Средняя освещённость (пасмурно).
* SOLAR_RAW = 2,5В → SOLAR_ADC ≈ 1,67В (K = 2/3).
.INCLUDE spice/SEN_SOLAR.sub

* Порты: GND SOLAR_ADC SOLAR_RAW

* V1: Датчик солнечной радиации: середина диапазона (2,5В)
V1 SOLAR_RAW 0 DC 2.5
XSEN_SOLAR 0 SOLAR_ADC SOLAR_RAW SEN_SOLAR

.op
.control
run
print v(solar_adc)
.endc
.end
