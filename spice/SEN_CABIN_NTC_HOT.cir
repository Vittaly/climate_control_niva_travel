* Ngspice тест: SEN_CABIN / SEN_CABIN_NTC_HOT
* Термистор RT1 прогрет до 60°C (труба продувки прогрета).
* R_NTC ≈ 2.49 кОм.
* Делитель: R_PU = 10к (R24 с листа UI), питание 3,3В.
* NTC_CABIN = 3.3 · 2.49/(10 + 2.49) ≈ 0.66В.
.INCLUDE spice/SEN_CABIN.sub

* Порты: GND M_FAN_CTL M_FAN_GATE NTC_CABIN SENS_FAN_SW VCC_12V

* V1: Опорное питание АЦП (эмуляция VCC_3V3 с листа UI)
V1 VCC_3V3_EXT 0 DC 3.3

* R_PU: R24 (10к) — верхнее плечо делителя, физически на UI
R_PU VCC_3V3_EXT NTC_CABIN 10k
XSEN_CABIN 0 M_FAN_CTL M_FAN_GATE NTC_CABIN SENS_FAN_SW VCC_12V SEN_CABIN RT1_T=60

.op
.control
run
print v(ntc_cabin)
.endc
.end
