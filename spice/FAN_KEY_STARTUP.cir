* Ngspice тест: FAN_KEY (порт-интерфейс из KiCad)

.INCLUDE hyg012n03_ngspice.lib
.INCLUDE motor_model.lab
.INCLUDE spice/FAN_KEY.sub
.model MyD D(IS=1e-6 RS=0.01 CJ=2n BV=60)
.model TVS24 D(IS=4.35e-9 RS=0.64 BV=8)
.model TVS5 D(IS=4.35e-9 RS=0.64 BV=5.6)
.model SW_GP SW(Ron=0.1 Roff=1Meg Vt=1.5 Vh=0.5)

* Порты: FAN_GATE_EXT FAN_LOAD_LO FAN_PWM_OUT GND MOTOR_TERM VBAT_FAN
XFAN_KEY FAN_GATE_EXT FAN_LOAD_LO FAN_PWM_OUT XGND MOTOR_TERM VBAT_FAN FAN_KEY
* мотор (motor_model.lab) + паразитные провода — только в тесте:
XMOT VBAT_FAN MOTOR_TERM SPEED DC_MOTOR_ADVANCED
R33 VBAT_SRC VBAT_FAN 0.015
L3  VBAT_SRC VBAT_FAN 1.5u
R34 XGND 0 0.015
L4  XGND 0 1.5u

VPWM FAN_PWM_OUT 0 DC 12
VB VBAT_SRC 0 DC 0 PULSE(0 13.5 0.5u 0.1u 0.1u 1 1)
.measure TRAN isurge MIN i(VB)
* PASS: пусковой бросок ~30А (ротор заторможен)
.control
tran 0.1m 0.5
* startup tran
run
.endc
.end
