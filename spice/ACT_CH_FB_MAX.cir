* Ngspice тест: ACTUATOR_CHANNEL / ACT_CH_FB_MAX
* Делитель ОС при максимальном положении потенциометра.
* 5В на FB_RAW → ~3,33В на FB.
.INCLUDE spice/ACTUATOR_CHANNEL.sub

* Порты: FB FB_RAW GND IN1 IN2 MOTOR_A MOTOR_B

* V1: Потенциометр заслонки в крайнем положении (5В)
V1 FB_RAW 0 DC 5.0
XACTUATOR_CHANNEL FB FB_RAW 0 IN1 IN2 MOTOR_A MOTOR_B ACTUATOR_CHANNEL

.op
.control
run
print v(fb)
.endc
.end
