* Ngspice тест: PWR / PWR_P1
* Переполюсовка входа: на J1:1,2 подан −14В.
* D1 (SS54) в обратном включении — ток ≈ 0,
* VBAT_PROT и VCC_12V остаются в нуле.
D_SS54 D(IS=4.35e-9 RS=0.05 BV=40)
D_SS14 D(IS=4.35e-9 RS=0.05 BV=40)
TVS24 D(IS=4.35e-9 RS=0.64 BV=24)
TVS5  D(IS=4.35e-9 RS=0.64 BV=5.6)
.INCLUDE spice/PWR.sub

* Порты: GND V5_SENS VBAT_IN

* V1: Аварийная переполюсовка входа −14В
V1 VBAT_IN 0 DC -14.0
XPWR 0 V5_SENS VBAT_IN PWR

.op
.control
run
print v(vbat_prot) v(vcc_12v)
.endc
.end
