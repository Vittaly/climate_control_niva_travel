* Ngspice тест: PWR (порт-интерфейс из KiCad)

.INCLUDE mc78m05_ngspice.lib
.INCLUDE ams1117_33_ngspice.lib

.INCLUDE spice/PWR.sub
.model MyD D(IS=4.35e-9 RS=0.64 BV=110)
.model TVS24 D(IS=4.35e-9 RS=0.64 BV=8)
.model TVS5 D(IS=4.35e-9 RS=0.64 BV=5.6)
.model SW_GP SW(Ron=0.1 Roff=1Meg Vt=1.5 Vh=0.5)

* Порты: AC_REQ_OUT CANH CANL COND_RAW FAN_PWM_OUT FB_M1_RAW FB_M2_RAW FB_M3_RAW FB_M4_RAW GND ILLUM_IN_RAW MOTOR_1_A MOTOR_1_B MOTOR_2_A MOTOR_2_B MOTOR_3_A MOTOR_3_B MOTOR_4_A MOTOR_4_B NTC_HEAT_W SOLAR_RAW V5_SENS VBAT_IN VBAT_PROT VCC_12V VCC_3V3 VCC_5V
XPWR AC_REQ_OUT CANH CANL COND_RAW FAN_PWM_OUT FB_M1_RAW FB_M2_RAW FB_M3_RAW FB_M4_RAW 0 ILLUM_IN_RAW MOTOR_1_A MOTOR_1_B MOTOR_2_A MOTOR_2_B MOTOR_3_A MOTOR_3_B MOTOR_4_A MOTOR_4_B NTC_HEAT_W SOLAR_RAW V5_SENS VBAT_IN VBAT_PROT VCC_12V VCC_3V3 VCC_5V PWR

VIN VBAT_IN 0 DC -14
.op
* PASS: V(VBAT_PROT)~0 и I(VIN)~0 (переполюсовка)
.control
op
print V(VBAT_PROT)
run
.endc
.end
