* Ngspice тест: PWR / PWR_P2
* Load-dump: на входе 40В (импульсный выброс от индуктивной
* нагрузки). TVS D2 (SMBJ15A) клиппит шину VCC_12V до ~24В.
D_SS54 D(IS=4.35e-9 RS=0.05 BV=40)
D_SS14 D(IS=4.35e-9 RS=0.05 BV=40)
TVS24 D(IS=4.35e-9 RS=0.64 BV=24)
TVS5  D(IS=4.35e-9 RS=0.64 BV=5.6)
.INCLUDE spice/PWR.sub

* Порты: AC_REQ_OUT CANH CANL COND_RAW FB_M1_RAW FB_M2_RAW FB_M3_RAW FB_M4_RAW GND HEAT_FAN_PWM_CTL ILLUM_IN_RAW MOTOR_1_A MOTOR_1_B MOTOR_2_A MOTOR_2_B MOTOR_3_A MOTOR_3_B MOTOR_4_A MOTOR_4_B NTC_HEAT_W SOLAR_RAW VCC_3V3

* V1: Аварийный выброс +40В
V1 VBAT_IN 0 DC 40.0
XPWR AC_REQ_OUT CANH CANL COND_RAW FB_M1_RAW FB_M2_RAW FB_M3_RAW FB_M4_RAW 0 HEAT_FAN_PWM_CTL ILLUM_IN_RAW MOTOR_1_A MOTOR_1_B MOTOR_2_A MOTOR_2_B MOTOR_3_A MOTOR_3_B MOTOR_4_A MOTOR_4_B NTC_HEAT_W SOLAR_RAW VCC_3V3 PWR

.op
.control
run
let v12 = v(VCC_12V)
let id2 = i(V1)
print v12 id2
.endc
.end
