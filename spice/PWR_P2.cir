* Ngspice тест: power_supply / PWR_P2
* Импульс load dump 38,4В через Ri = 0,5 Ом (ISO 7637-2).
* TVS D2 в пробое удерживает VCC_12V в районе 24–26В,
* ток пробоя 20–30А рассеивается на диоде.
.INCLUDE /home/vitaly-pc/kicad/climate_control_niva_travel/spice/lib/mc78m05_ngspice.lib
.INCLUDE /home/vitaly-pc/kicad/climate_control_niva_travel/spice/lib/ams1117_33_ngspice.lib
.model D_SS54 D(IS=4.35e-9 RS=0.05 BV=40)
.model TVS24 D(IS=1e-14 RS=0.05 BV=24 IBV=1m N=1.05 CJO=200p)
.model D_SS14 D(IS=4.35e-9 RS=0.05 BV=40)
.model TVS5 D(IS=4.35e-9 RS=0.05 BV=5.6 IBV=1m N=1.05 CJO=200p)
.INCLUDE spice/power_supply.sub

* Порты: AC_REQ_OUT CANH CANL COND_IN_RAW FB_M1_RAW FB_M2_RAW FB_M3_RAW FB_M4_RAW GND HEAT_FAN_PWM_CTL ILLUM_IN_RAW MOTOR_1_A MOTOR_1_B MOTOR_2_A MOTOR_2_B MOTOR_3_A MOTOR_3_B MOTOR_4_A MOTOR_4_B NTC_HEAT_W SOLAR_IN_RAW V5_SENS VBAT_IN VBAT_PROT VCC_12V VCC_3V3 VCC_5V

* V1: Импульс load dump 38,4В (пик)
V1 VCC_SRC 0 DC 38.4

* R_LD: Внутреннее сопротивление источника (ISO 7637-2)
R_LD VCC_SRC VCC_12V 0.5
Xpower_supply AC_REQ_OUT CANH CANL COND_IN_RAW FB_M1_RAW FB_M2_RAW FB_M3_RAW FB_M4_RAW 0 HEAT_FAN_PWM_CTL ILLUM_IN_RAW MOTOR_1_A MOTOR_1_B MOTOR_2_A MOTOR_2_B MOTOR_3_A MOTOR_3_B MOTOR_4_A MOTOR_4_B NTC_HEAT_W SOLAR_IN_RAW V5_SENS VBAT_IN VBAT_PROT VCC_12V VCC_3V3 VCC_5V power_supply

.op
.control
run
let v12 = v(VCC_12V)
let id2 = i(V1)
print v12 id2
.endc
.end
