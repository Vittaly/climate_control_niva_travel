* Ngspice тест: PWR / PWR_P2
* Load-dump: на входе 40В (импульсный выброс от индуктивной
* нагрузки). TVS D2 (SMBJ15A) клиппит шину VCC_12V до ~24В.
D_SS54 D(IS=4.35e-9 RS=0.05 BV=40)
D_SS14 D(IS=4.35e-9 RS=0.05 BV=40)
TVS24 D(IS=4.35e-9 RS=0.64 BV=24)
TVS5  D(IS=4.35e-9 RS=0.64 BV=5.6)
.INCLUDE spice/PWR.sub

* Порты: GND V5_SENS VBAT_IN

* V1: Аварийный выброс +40В
V1 VBAT_IN 0 DC 40.0
XPWR 0 V5_SENS VBAT_IN PWR

.op
.control
run
let v12 = v(VCC_12V)
let id2 = i(V1)
print v12 id2
.endc
.end
