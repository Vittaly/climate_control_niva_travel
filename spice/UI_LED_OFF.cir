* Ngspice тест: UI / UI_LED_OFF
* Индикатор LED1 выключен (катод на 3,3В с МК)
LED_GREEN D(IS=1e-20 N=1.8 RS=8 BV=5 CJO=10p)
LED_AMBER D(IS=1e-20 N=1.8 RS=8 BV=5 CJO=10p)
SW_GP    SW(Ron=0.1 Roff=1Meg Vt=1.5 Vh=0.5)
.INCLUDE spice/UI.sub

* Порты: BTN_DRY_GLASS BTN_FACE BTN_FEET FAN_SEL_ADC GND LED_AC_DRV LED_DEFROST_GLASS_DRV LED_DRY_GLASS_DRV LED_FACE_DRV LED_FEET_DRV LED_RECIRC_DRV

V1 VCC_3V3 0 DC 3.3

V2 LED_DEFROST_GLASS_DRV 0 DC 3.3
XUI BTN_DRY_GLASS BTN_FACE BTN_FEET FAN_SEL_ADC 0 LED_AC_DRV LED_DEFROST_GLASS_DRV LED_DRY_GLASS_DRV LED_FACE_DRV LED_FEET_DRV LED_RECIRC_DRV UI

.op
.control
run
let icc = -i(V1)
print icc
.endc
.end
