* Ngspice тест: ACTUATOR_CHANNEL / ACT_CH_FB_MIN
* Делитель ОС при минимальном положении потенциометра.
* 0В на FB_RAW → 0В на FB.
.INCLUDE spice/ACTUATOR_CHANNEL.sub

* Порты: FB FB_RAW GND IN1 IN2 MOTOR_A MOTOR_B

* V1: Потенциометр заслонки в крайнем положении (0В)
V1 FB_RAW 0 DC 0.0
XACTUATOR_CHANNEL FB FB_RAW 0 IN1 IN2 MOTOR_A MOTOR_B ACTUATOR_CHANNEL

.op
.control
run
print v(fb)
.endc
.end
