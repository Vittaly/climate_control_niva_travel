* Ngspice тест: ACTUATOR_CHANNEL / ACT_CH_FB_MIN
* Делитель ОС при минимальном положении потенциометра.
* 0В на FB_RAW → 0В на FB.
.INCLUDE spice/ACTUATOR_CHANNEL.sub

* Порты: GND IN2

* V1: Потенциометр заслонки в крайнем положении (0В)
V1 FB_RAW 0 DC 0.0
XACTUATOR_CHANNEL 0 IN2 ACTUATOR_CHANNEL

.op
.control
run
print v(fb)
.endc
.end
