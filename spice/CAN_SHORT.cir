* Ngspice тест: can_bus / CAN_SHORT
* Проверка поведения при КЗ CANH на CANL через низкоомный
* шунт (имитация повреждения шины).
* Драйвер активен, но ток ограничен внутренней защитой.
* Проверяем, что CANH не проваливается к нулю мгновенно,
* а Vdiff остаётся в разумных пределах.
.INCLUDE /home/vitaly-pc/kicad/climate_control_niva_travel/spice/lib/mcp2562_ngspice.lib
.INCLUDE spice/can_bus.sub

* Порты: CANH CANL CAN_RX CAN_TX GND VCC_5V

* V1: Питание трансивера
V1 VCC_5V 0 DC 5.0

* V2: TXD = 0 (драйвер активен)
V2 CAN_TX 0 DC 0.0

* R_SHORT: Имитация КЗ CANH-CANL (1 Ом)
R_SHORT CANH CANL 1

* R_TERM: Эквивалент двух терминаторов 120 Ом на концах шины
R_TERM CANH CANL 60
Xcan_bus CANH CANL CAN_RX CAN_TX 0 VCC_5V can_bus

.op
.control
run
let vh    = v(CANH)
let vl    = v(CANL)
let ish   = (v(CANH) - v(CANL)) / 1
print vh vl ish
.endc
.end
