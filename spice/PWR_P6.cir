* Ngspice тест: power_supply / PWR_P6
* Обратная подача +12В на линию датчиков V5_SENS (J1:17).
* Штатно V5_SENS питается через D4 (SS14) от VCC_5V.
* Аварийный случай: снаружи через разъём приходит +12В.
* Источник V2 подключён через R_INJ=100 Ом (имитация жгута
* и Ri внешнего драйвера) — TVS D5 в пробое прижимает
* V5_SENS к ~5,6В. Проверяем, что D4 заперт и обратная
* подача не поднимает внутреннюю шину +5В.
.INCLUDE /home/vitaly-pc/kicad/climate_control_niva_travel/spice/lib/mc78m05_ngspice.lib
.INCLUDE /home/vitaly-pc/kicad/climate_control_niva_travel/spice/lib/ams1117_33_ngspice.lib
.model D_SS54 D(IS=4.35e-9 RS=0.05 BV=40)
.model TVS24 D(IS=1e-14 RS=0.05 BV=24 IBV=1m N=1.05 CJO=200p)
.model D_SS14 D(IS=4.35e-9 RS=0.05 BV=40)
.model TVS5 D(IS=4.35e-9 RS=0.05 BV=5.6 IBV=1m N=1.05 CJO=200p)
.INCLUDE spice/power_supply.sub

* Порты: AC_REQ_OUT CANH CANL COND_IN_RAW FB_M1_RAW FB_M2_RAW FB_M3_RAW FB_M4_RAW GND HEAT_FAN_PWM_CTL ILLUM_IN_RAW MOTOR_1_A MOTOR_1_B MOTOR_2_A MOTOR_2_B MOTOR_3_A MOTOR_3_B MOTOR_4_A MOTOR_4_B NTC_HEAT_W SOLAR_IN_RAW V5_SENS VBAT_IN VBAT_PROT VCC_12V VCC_3V3 VCC_5V

* V1: Номинальная бортсеть +14,4В
V1 VBAT_IN 0 DC 14.4

* V2: Аварийная обратная подача +12В через J1:17
V2 V5_EXT 0 DC 12.0

* R_INJ: Ri жгута и внешнего источника затекания (100 Ом)
R_INJ V5_EXT V5_SENS 100

* R_L5V: Нагрузка на +5В
R_L5V VCC_5V 0 100
Xpower_supply AC_REQ_OUT CANH CANL COND_IN_RAW FB_M1_RAW FB_M2_RAW FB_M3_RAW FB_M4_RAW 0 HEAT_FAN_PWM_CTL ILLUM_IN_RAW MOTOR_1_A MOTOR_1_B MOTOR_2_A MOTOR_2_B MOTOR_3_A MOTOR_3_B MOTOR_4_A MOTOR_4_B NTC_HEAT_W SOLAR_IN_RAW V5_SENS VBAT_IN VBAT_PROT VCC_12V VCC_3V3 VCC_5V power_supply

.op
.control
run
let v5   = v(VCC_5V)
let vsen = v(V5_SENS)
print v5 vsen
.endc
.end
