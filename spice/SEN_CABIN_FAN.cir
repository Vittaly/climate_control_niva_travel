* Ngspice тест: SEN_CABIN (порт-интерфейс из KiCad)

.INCLUDE spice/SEN_CABIN.sub
.model MyD D(IS=4.35e-9 RS=0.64 BV=110)
.model TVS24 D(IS=4.35e-9 RS=0.64 BV=8)
.model TVS5 D(IS=4.35e-9 RS=0.64 BV=5.6)
.model SW_GP SW(Ron=0.1 Roff=1Meg Vt=1.5 Vh=0.5)

* Порты: GND M_FAN_CTL M_FAN_GATE NTC_CABIN SENS_FAN_SW VCC_12V
XSEN_CABIN 0 M_FAN_CTL M_FAN_GATE NTC_CABIN SENS_FAN_SW VCC_12V SEN_CABIN

VS VCC_12V 0 DC 14.4
V1 M_FAN_CTL 0 DC 3.3
.op
* PASS: SENS_FAN_SW ~0 (вентилятор включён)
.control
op
print V(SENS_FAN_SW)
run
.endc
.end
