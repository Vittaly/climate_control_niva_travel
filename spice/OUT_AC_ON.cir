* Ngspice тест: OUT / OUT_AC_ON
* AC_CTL = 3,3В → Q3 открыт (Ib ≈ 0,26 мА) → база Q4 прижата к GND
* через Q3, Q4 открыт высокосторонним ключом. AC_REQ_OUT ≈ 12В.
BSS138 NMOS(VTO=1.3 KP=0.5 LAMBDA=0.02)
MMBT3904 NPN(IS=1e-14 BF=200 VAF=100 IKF=0.3)
MMBT3906 PNP(IS=1e-14 BF=150 VAF=100 IKF=0.3)
.INCLUDE spice/OUT.sub

* Порты: AC_BASE AC_CTL AC_PNP_BASE AC_REQ AC_REQ_OUT FAN_GATE FAN_PWM_CTL FAN_PWM_NODE GND HEAT_FAN_PWM_CTL VCC_12V

* V1: Питание модуля +14,4В
V1 VCC_12V 0 DC 14.4

* V2: Управление запросом кондиционера = 3,3В
V2 AC_CTL 0 DC 3.3

* R_ECU: Внешний вход ЭБУ (10 кОм на GND)
R_ECU AC_REQ_OUT 0 10k
XOUT AC_BASE AC_CTL AC_PNP_BASE AC_REQ AC_REQ_OUT FAN_GATE FAN_PWM_CTL FAN_PWM_NODE 0 HEAT_FAN_PWM_CTL VCC_12V OUT

.op
.control
run
let vac  = v(AC_REQ_OUT)
let iecu = vac / 10k
print vac iecu
.endc
.end
